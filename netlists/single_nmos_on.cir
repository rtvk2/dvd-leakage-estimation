* Single-transistor netlist: NMOS ON (16nm_HP, nominal process)
.include "../Model Files-20261105/models/16nm_HP.pm"
.options gmin=1e-18 abstol=1e-18 reltol=1e-6 vntol=1e-9

* geometry and bias of this example (the datasets sample these and the process parameters at random)
.param Lmin=1.6e-08
.param Ldiff=3.2e-08
.param Wd=1.6e-08
.param vdd=0.9

* device with junction areas AD = AS = W*Ldiff, one voltage source per terminal
Mn d g s b nmos W={Wd} L={Lmin} AD={Wd*Ldiff} AS={Wd*Ldiff}
Vd d 0 0.9
Vg g 0 0.9
Vs s 0 0
Vb b 0 0

.control
set numdgt = 15
set temp = 27
* one altermod per parameter (only the first parameter on a line is applied)
altermod nmos vth0=0.47965
altermod nmos toxe=9.5e-10
altermod nmos ndep=7e+18
altermod nmos u0=0.03
altermod nmos xj=5e-09
op
print i(vd) i(vg) i(vs) i(vb)
.endc
.end
