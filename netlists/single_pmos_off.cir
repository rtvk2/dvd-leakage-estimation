* Single-transistor netlist: PMOS OFF (16nm_HP, nominal process)
.include "../Model Files-20261105/models/16nm_HP.pm"
.options gmin=1e-18 abstol=1e-18 reltol=1e-6 vntol=1e-9

* geometry and bias of this example (the datasets sample these and the process parameters at random)
.param Lmin=1.6e-08
.param Ldiff=3.2e-08
.param Wd=1.6e-08
.param vdd=0.9

* device with junction areas AD = AS = W*Ldiff, one voltage source per terminal
Mp d g s b pmos W={Wd} L={Lmin} AD={Wd*Ldiff} AS={Wd*Ldiff}
Vd d 0 0
Vg g 0 0.9
Vs s 0 0.9
Vb b 0 0.9

.control
set numdgt = 15
set temp = 27
* one altermod per parameter (only the first parameter on a line is applied)
altermod pmos vth0=-0.43121
altermod pmos toxe=1e-09
altermod pmos ndep=5.5e+18
altermod pmos u0=0.006
altermod pmos xj=5e-09
op
print i(vd) i(vg) i(vs) i(vb)
.endc
.end
